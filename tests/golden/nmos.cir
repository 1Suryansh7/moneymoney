* cell nmos_golden
Xm1 drain gate source vss sky130_fd_pr__nfet_01v8 L=1.5e-07 W=1e-06
.end
